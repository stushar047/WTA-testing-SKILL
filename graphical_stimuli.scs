_vVb (Vb 0) vsource dc=0 type=dc
_vVg (Vg 0) vsource dc=1.2 type=dc
_vVt (Vt 0) vsource val0=0 val1=0.6 period=8u delay=1n rise=1p fall=1p width=4u type=pulse
