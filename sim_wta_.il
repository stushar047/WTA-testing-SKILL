load("wta.il");

load("graphics_wta.il");

load("utils.il");

vdd = 1.2

;vc =0.8

;vc_list = make_list(1.0 1.6 0.1)

vc_list = '(1.1)

;I1_list = '(11.96u 10.95u 23.75u 3.92u)

;I2_list = '(7.428u  13.28u 24.72u  3.92u)

;I3_list = '(7.428u 12.55u 26.83u 3.92u)

;I4_list = '(7.428u 10.95u 21.49u 6.19u)

I1_list = '(3.9592e-06 3.9592e-06 3.9592e-06 3.9592e-06 3.9592e-06 3.9592e-06 3.9592e-06 3.9592e-06 3.9592e-06 3.9592e-06 3.9592e-06 3.9592e-06 3.9592e-06 3.9592e-06 3.9592e-06 3.9592e-06 3.9592e-06 3.9592e-06 3.9592e-06 3.9592e-06 3.9592e-06 3.9592e-06 3.9592e-06 3.9592e-06 3.9592e-06 3.9592e-06 3.9592e-06 3.9592e-06 3.9592e-06 3.9592e-06 3.9592e-06 3.9592e-06 3.9592e-06 3.9592e-06 3.9592e-06 3.9592e-06 3.9592e-06 3.9592e-06 3.9592e-06 3.9592e-06 3.9592e-06 3.9592e-06 3.9592e-06 3.9592e-06 3.9592e-06 3.9592e-06 3.9592e-06 3.9592e-06 3.9592e-06 3.9592e-06 3.9592e-06 3.9592e-06 3.9592e-06 3.9592e-06 3.9592e-06 3.9592e-06 3.9592e-06 3.9592e-06 3.9592e-06 3.9592e-06 3.9592e-06 3.9592e-06 3.9592e-06 3.9592e-06 3.9592e-06 3.9592e-06 3.9592e-06 3.9592e-06 3.9592e-06 3.9592e-06 3.9592e-06 3.9592e-06 3.9592e-06 3.9592e-06 3.9592e-06 3.9592e-06 3.9592e-06 3.9592e-06 3.9592e-06 3.9592e-06 3.9592e-06 3.9592e-06 3.9592e-06 3.9592e-06 3.9592e-06 3.9592e-06 3.9592e-06 3.9592e-06 3.9592e-06 3.9592e-06 3.9592e-06 3.9592e-06 3.9592e-06 3.9592e-06 3.9592e-06 3.9592e-06 3.9592e-06 3.9592e-06 3.9592e-06 3.9592e-06 3.9592e-06 3.9592e-06 3.9592e-06 3.9592e-06 3.9592e-06 3.9592e-06 3.9592e-06 3.9592e-06 3.9592e-06 3.9592e-06 3.9592e-06 3.9592e-06 3.9592e-06 3.9592e-06 3.9592e-06 3.9592e-06 3.9592e-06 3.9592e-06 3.9592e-06 3.9592e-06 3.9592e-06 3.9592e-06 3.9592e-06 3.9592e-06 3.9592e-06 4.0376e-06 4.0376e-06 4.0376e-06 4.0376e-06 4.0376e-06 4.0376e-06 4.0376e-06 4.0376e-06 4.0376e-06 4.0376e-06 4.0376e-06 4.0376e-06 4.0376e-06 4.0376e-06 4.0376e-06 4.0376e-06 4.0376e-06 4.0376e-06 4.0376e-06 4.0376e-06 4.0376e-06 4.0376e-06 4.0376e-06 4.0376e-06 4.0376e-06 4.0376e-06 4.0376e-06 4.0376e-06 4.0376e-06 4.0376e-06 4.0376e-06 4.0376e-06 4.0376e-06 4.0376e-06 4.0376e-06 4.0376e-06 4.0376e-06 4.0376e-06 4.0376e-06 4.0376e-06 4.0376e-06 4.0376e-06 4.0376e-06 4.0376e-06 4.0376e-06 4.0376e-06 4.0376e-06 4.0376e-06 4.0376e-06 4.0376e-06 4.0376e-06 4.0376e-06 4.0376e-06 4.0376e-06 4.0376e-06 4.0376e-06 4.0376e-06 4.0376e-06 4.0376e-06 4.0376e-06 4.0376e-06 4.0376e-06 4.0376e-06 4.0376e-06 4.0376e-06 4.0376e-06 4.0376e-06 4.0376e-06 4.0376e-06 4.0376e-06 4.0376e-06 4.0376e-06 4.0376e-06 4.0376e-06 4.0376e-06 4.0376e-06 4.0376e-06 4.0376e-06 4.0376e-06 4.0376e-06 4.0376e-06 4.0376e-06 4.0376e-06 4.0376e-06 4.0376e-06 4.0376e-06 4.0376e-06 4.0376e-06 4.0376e-06 4.0376e-06 4.0376e-06 4.0376e-06 4.0376e-06 4.0376e-06 4.0376e-06 4.0376e-06 4.0376e-06 4.0376e-06 4.0376e-06 4.0376e-06 4.0376e-06 4.0376e-06 4.0376e-06 4.0376e-06 4.0376e-06 4.0376e-06 4.0376e-06 4.0376e-06 4.0376e-06 4.0376e-06 4.0376e-06 4.0376e-06 4.0376e-06 4.0376e-06 4.0376e-06 4.0376e-06 4.0376e-06 4.0376e-06 4.0376e-06 4.0376e-06 4.0376e-06 4.0376e-06 4.0376e-06 4.0376e-06 4.0376e-06 4.116e-06 4.116e-06 4.116e-06 4.116e-06 4.116e-06 4.116e-06 4.116e-06 4.116e-06 4.116e-06 4.116e-06 4.116e-06 4.116e-06 4.116e-06 4.116e-06 4.116e-06 4.116e-06 4.116e-06 4.116e-06 4.116e-06 4.116e-06 4.116e-06 4.116e-06 4.116e-06 4.116e-06 4.116e-06 4.116e-06 4.116e-06 4.116e-06 4.116e-06 4.116e-06 4.116e-06 4.116e-06 4.116e-06 4.116e-06 4.116e-06 4.116e-06 4.116e-06 4.116e-06 4.116e-06 4.116e-06 4.116e-06 4.116e-06 4.116e-06 4.116e-06 4.116e-06 4.116e-06 4.116e-06 4.116e-06 4.116e-06 4.116e-06 4.116e-06 4.116e-06 4.116e-06 4.116e-06 4.116e-06 4.116e-06 4.116e-06 4.116e-06 4.116e-06 4.116e-06 4.116e-06 4.116e-06 4.116e-06 4.116e-06 4.116e-06 4.116e-06 4.116e-06 4.116e-06 4.116e-06 4.116e-06 4.116e-06 4.116e-06 4.116e-06 4.116e-06 4.116e-06 4.116e-06 4.116e-06 4.116e-06 4.116e-06 4.116e-06 4.116e-06 4.116e-06 4.116e-06 4.116e-06 4.116e-06 4.116e-06 4.116e-06 4.116e-06 4.116e-06 4.116e-06 4.116e-06 4.116e-06 4.116e-06 4.116e-06 4.116e-06 4.116e-06 4.116e-06 4.116e-06 4.116e-06 4.116e-06 4.116e-06 4.116e-06 4.116e-06 4.116e-06 4.116e-06 4.116e-06 4.116e-06 4.116e-06 4.116e-06 4.116e-06 4.116e-06 4.116e-06 4.116e-06 4.116e-06 4.116e-06 4.116e-06 4.116e-06 4.116e-06 4.116e-06 4.116e-06 4.116e-06 4.116e-06 4.116e-06 4.116e-06 4.116e-06 4.1944e-06 4.1944e-06 4.1944e-06 4.1944e-06 4.1944e-06 4.1944e-06 4.1944e-06 4.1944e-06 4.1944e-06 4.1944e-06 4.1944e-06 4.1944e-06 4.1944e-06 4.1944e-06 4.1944e-06 4.1944e-06 4.1944e-06 4.1944e-06 4.1944e-06 4.1944e-06 4.1944e-06 4.1944e-06 4.1944e-06 4.1944e-06 4.1944e-06 4.1944e-06 4.1944e-06 4.1944e-06 4.1944e-06 4.1944e-06 4.1944e-06 4.1944e-06 4.1944e-06 4.1944e-06 4.1944e-06 4.1944e-06 4.1944e-06 4.1944e-06 4.1944e-06 4.1944e-06 4.1944e-06 4.1944e-06 4.1944e-06 4.1944e-06 4.1944e-06 4.1944e-06 4.1944e-06 4.1944e-06 4.1944e-06 4.1944e-06 4.1944e-06 4.1944e-06 4.1944e-06 4.1944e-06 4.1944e-06 4.1944e-06 4.1944e-06 4.1944e-06 4.1944e-06 4.1944e-06 4.1944e-06 4.1944e-06 4.1944e-06 4.1944e-06 4.1944e-06 4.1944e-06 4.1944e-06 4.1944e-06 4.1944e-06 4.1944e-06 4.1944e-06 4.1944e-06 4.1944e-06 4.1944e-06 4.1944e-06 4.1944e-06 4.1944e-06 4.1944e-06 4.1944e-06 4.1944e-06 4.1944e-06 4.1944e-06 4.1944e-06 4.1944e-06 4.1944e-06 4.1944e-06 4.1944e-06 4.1944e-06 4.1944e-06 4.1944e-06 4.1944e-06 4.1944e-06 4.1944e-06 4.1944e-06 4.1944e-06 4.1944e-06 4.1944e-06 4.1944e-06 4.1944e-06 4.1944e-06 4.1944e-06 4.1944e-06 4.1944e-06 4.1944e-06 4.1944e-06 4.1944e-06 4.1944e-06 4.1944e-06 4.1944e-06 4.1944e-06 4.1944e-06 4.1944e-06 4.1944e-06 4.1944e-06 4.1944e-06 4.1944e-06 4.1944e-06 4.1944e-06 4.1944e-06 4.1944e-06 4.1944e-06 4.1944e-06 4.1944e-06 4.1944e-06 4.1944e-06 4.2728e-06 4.2728e-06 4.2728e-06 4.2728e-06 4.2728e-06 4.2728e-06 4.2728e-06 4.2728e-06 4.2728e-06 4.2728e-06 4.2728e-06 4.2728e-06 4.2728e-06 4.2728e-06 4.2728e-06 4.2728e-06 4.2728e-06 4.2728e-06 4.2728e-06 4.2728e-06 4.2728e-06 4.2728e-06 4.2728e-06 4.2728e-06 4.2728e-06 4.2728e-06 4.2728e-06 4.2728e-06 4.2728e-06 4.2728e-06 4.2728e-06 4.2728e-06 4.2728e-06 4.2728e-06 4.2728e-06 4.2728e-06 4.2728e-06 4.2728e-06 4.2728e-06 4.2728e-06 4.2728e-06 4.2728e-06 4.2728e-06 4.2728e-06 4.2728e-06 4.2728e-06 4.2728e-06 4.2728e-06 4.2728e-06 4.2728e-06 4.2728e-06 4.2728e-06 4.2728e-06 4.2728e-06 4.2728e-06 4.2728e-06 4.2728e-06 4.2728e-06 4.2728e-06 4.2728e-06 4.2728e-06 4.2728e-06 4.2728e-06 4.2728e-06 4.2728e-06 4.2728e-06 4.2728e-06 4.2728e-06 4.2728e-06 4.2728e-06 4.2728e-06 4.2728e-06 4.2728e-06 4.2728e-06 4.2728e-06 4.2728e-06 4.2728e-06 4.2728e-06 4.2728e-06 4.2728e-06 4.2728e-06 4.2728e-06 4.2728e-06 4.2728e-06 4.2728e-06 4.2728e-06 4.2728e-06 4.2728e-06 4.2728e-06 4.2728e-06 4.2728e-06 4.2728e-06 4.2728e-06 4.2728e-06 4.2728e-06 4.2728e-06 4.2728e-06 4.2728e-06 4.2728e-06 4.2728e-06 4.2728e-06 4.2728e-06 4.2728e-06 4.2728e-06 4.2728e-06 4.2728e-06 4.2728e-06 4.2728e-06 4.2728e-06 4.2728e-06 4.2728e-06 4.2728e-06 4.2728e-06 4.2728e-06 4.2728e-06 4.2728e-06 4.2728e-06 4.2728e-06 4.2728e-06 4.2728e-06 4.2728e-06 4.2728e-06 4.2728e-06 4.2728e-06 4.2728e-06 )
I2_list = '(3.9592e-06 3.9592e-06 3.9592e-06 3.9592e-06 3.9592e-06 3.9592e-06 3.9592e-06 3.9592e-06 3.9592e-06 3.9592e-06 3.9592e-06 3.9592e-06 3.9592e-06 3.9592e-06 3.9592e-06 3.9592e-06 3.9592e-06 3.9592e-06 3.9592e-06 3.9592e-06 3.9592e-06 3.9592e-06 3.9592e-06 3.9592e-06 3.9592e-06 4.0376e-06 4.0376e-06 4.0376e-06 4.0376e-06 4.0376e-06 4.0376e-06 4.0376e-06 4.0376e-06 4.0376e-06 4.0376e-06 4.0376e-06 4.0376e-06 4.0376e-06 4.0376e-06 4.0376e-06 4.0376e-06 4.0376e-06 4.0376e-06 4.0376e-06 4.0376e-06 4.0376e-06 4.0376e-06 4.0376e-06 4.0376e-06 4.0376e-06 4.116e-06 4.116e-06 4.116e-06 4.116e-06 4.116e-06 4.116e-06 4.116e-06 4.116e-06 4.116e-06 4.116e-06 4.116e-06 4.116e-06 4.116e-06 4.116e-06 4.116e-06 4.116e-06 4.116e-06 4.116e-06 4.116e-06 4.116e-06 4.116e-06 4.116e-06 4.116e-06 4.116e-06 4.116e-06 4.1944e-06 4.1944e-06 4.1944e-06 4.1944e-06 4.1944e-06 4.1944e-06 4.1944e-06 4.1944e-06 4.1944e-06 4.1944e-06 4.1944e-06 4.1944e-06 4.1944e-06 4.1944e-06 4.1944e-06 4.1944e-06 4.1944e-06 4.1944e-06 4.1944e-06 4.1944e-06 4.1944e-06 4.1944e-06 4.1944e-06 4.1944e-06 4.1944e-06 4.2728e-06 4.2728e-06 4.2728e-06 4.2728e-06 4.2728e-06 4.2728e-06 4.2728e-06 4.2728e-06 4.2728e-06 4.2728e-06 4.2728e-06 4.2728e-06 4.2728e-06 4.2728e-06 4.2728e-06 4.2728e-06 4.2728e-06 4.2728e-06 4.2728e-06 4.2728e-06 4.2728e-06 4.2728e-06 4.2728e-06 4.2728e-06 4.2728e-06 3.9592e-06 3.9592e-06 3.9592e-06 3.9592e-06 3.9592e-06 3.9592e-06 3.9592e-06 3.9592e-06 3.9592e-06 3.9592e-06 3.9592e-06 3.9592e-06 3.9592e-06 3.9592e-06 3.9592e-06 3.9592e-06 3.9592e-06 3.9592e-06 3.9592e-06 3.9592e-06 3.9592e-06 3.9592e-06 3.9592e-06 3.9592e-06 3.9592e-06 4.0376e-06 4.0376e-06 4.0376e-06 4.0376e-06 4.0376e-06 4.0376e-06 4.0376e-06 4.0376e-06 4.0376e-06 4.0376e-06 4.0376e-06 4.0376e-06 4.0376e-06 4.0376e-06 4.0376e-06 4.0376e-06 4.0376e-06 4.0376e-06 4.0376e-06 4.0376e-06 4.0376e-06 4.0376e-06 4.0376e-06 4.0376e-06 4.0376e-06 4.116e-06 4.116e-06 4.116e-06 4.116e-06 4.116e-06 4.116e-06 4.116e-06 4.116e-06 4.116e-06 4.116e-06 4.116e-06 4.116e-06 4.116e-06 4.116e-06 4.116e-06 4.116e-06 4.116e-06 4.116e-06 4.116e-06 4.116e-06 4.116e-06 4.116e-06 4.116e-06 4.116e-06 4.116e-06 4.1944e-06 4.1944e-06 4.1944e-06 4.1944e-06 4.1944e-06 4.1944e-06 4.1944e-06 4.1944e-06 4.1944e-06 4.1944e-06 4.1944e-06 4.1944e-06 4.1944e-06 4.1944e-06 4.1944e-06 4.1944e-06 4.1944e-06 4.1944e-06 4.1944e-06 4.1944e-06 4.1944e-06 4.1944e-06 4.1944e-06 4.1944e-06 4.1944e-06 4.2728e-06 4.2728e-06 4.2728e-06 4.2728e-06 4.2728e-06 4.2728e-06 4.2728e-06 4.2728e-06 4.2728e-06 4.2728e-06 4.2728e-06 4.2728e-06 4.2728e-06 4.2728e-06 4.2728e-06 4.2728e-06 4.2728e-06 4.2728e-06 4.2728e-06 4.2728e-06 4.2728e-06 4.2728e-06 4.2728e-06 4.2728e-06 4.2728e-06 3.9592e-06 3.9592e-06 3.9592e-06 3.9592e-06 3.9592e-06 3.9592e-06 3.9592e-06 3.9592e-06 3.9592e-06 3.9592e-06 3.9592e-06 3.9592e-06 3.9592e-06 3.9592e-06 3.9592e-06 3.9592e-06 3.9592e-06 3.9592e-06 3.9592e-06 3.9592e-06 3.9592e-06 3.9592e-06 3.9592e-06 3.9592e-06 3.9592e-06 4.0376e-06 4.0376e-06 4.0376e-06 4.0376e-06 4.0376e-06 4.0376e-06 4.0376e-06 4.0376e-06 4.0376e-06 4.0376e-06 4.0376e-06 4.0376e-06 4.0376e-06 4.0376e-06 4.0376e-06 4.0376e-06 4.0376e-06 4.0376e-06 4.0376e-06 4.0376e-06 4.0376e-06 4.0376e-06 4.0376e-06 4.0376e-06 4.0376e-06 4.116e-06 4.116e-06 4.116e-06 4.116e-06 4.116e-06 4.116e-06 4.116e-06 4.116e-06 4.116e-06 4.116e-06 4.116e-06 4.116e-06 4.116e-06 4.116e-06 4.116e-06 4.116e-06 4.116e-06 4.116e-06 4.116e-06 4.116e-06 4.116e-06 4.116e-06 4.116e-06 4.116e-06 4.116e-06 4.1944e-06 4.1944e-06 4.1944e-06 4.1944e-06 4.1944e-06 4.1944e-06 4.1944e-06 4.1944e-06 4.1944e-06 4.1944e-06 4.1944e-06 4.1944e-06 4.1944e-06 4.1944e-06 4.1944e-06 4.1944e-06 4.1944e-06 4.1944e-06 4.1944e-06 4.1944e-06 4.1944e-06 4.1944e-06 4.1944e-06 4.1944e-06 4.1944e-06 4.2728e-06 4.2728e-06 4.2728e-06 4.2728e-06 4.2728e-06 4.2728e-06 4.2728e-06 4.2728e-06 4.2728e-06 4.2728e-06 4.2728e-06 4.2728e-06 4.2728e-06 4.2728e-06 4.2728e-06 4.2728e-06 4.2728e-06 4.2728e-06 4.2728e-06 4.2728e-06 4.2728e-06 4.2728e-06 4.2728e-06 4.2728e-06 4.2728e-06 3.9592e-06 3.9592e-06 3.9592e-06 3.9592e-06 3.9592e-06 3.9592e-06 3.9592e-06 3.9592e-06 3.9592e-06 3.9592e-06 3.9592e-06 3.9592e-06 3.9592e-06 3.9592e-06 3.9592e-06 3.9592e-06 3.9592e-06 3.9592e-06 3.9592e-06 3.9592e-06 3.9592e-06 3.9592e-06 3.9592e-06 3.9592e-06 3.9592e-06 4.0376e-06 4.0376e-06 4.0376e-06 4.0376e-06 4.0376e-06 4.0376e-06 4.0376e-06 4.0376e-06 4.0376e-06 4.0376e-06 4.0376e-06 4.0376e-06 4.0376e-06 4.0376e-06 4.0376e-06 4.0376e-06 4.0376e-06 4.0376e-06 4.0376e-06 4.0376e-06 4.0376e-06 4.0376e-06 4.0376e-06 4.0376e-06 4.0376e-06 4.116e-06 4.116e-06 4.116e-06 4.116e-06 4.116e-06 4.116e-06 4.116e-06 4.116e-06 4.116e-06 4.116e-06 4.116e-06 4.116e-06 4.116e-06 4.116e-06 4.116e-06 4.116e-06 4.116e-06 4.116e-06 4.116e-06 4.116e-06 4.116e-06 4.116e-06 4.116e-06 4.116e-06 4.116e-06 4.1944e-06 4.1944e-06 4.1944e-06 4.1944e-06 4.1944e-06 4.1944e-06 4.1944e-06 4.1944e-06 4.1944e-06 4.1944e-06 4.1944e-06 4.1944e-06 4.1944e-06 4.1944e-06 4.1944e-06 4.1944e-06 4.1944e-06 4.1944e-06 4.1944e-06 4.1944e-06 4.1944e-06 4.1944e-06 4.1944e-06 4.1944e-06 4.1944e-06 4.2728e-06 4.2728e-06 4.2728e-06 4.2728e-06 4.2728e-06 4.2728e-06 4.2728e-06 4.2728e-06 4.2728e-06 4.2728e-06 4.2728e-06 4.2728e-06 4.2728e-06 4.2728e-06 4.2728e-06 4.2728e-06 4.2728e-06 4.2728e-06 4.2728e-06 4.2728e-06 4.2728e-06 4.2728e-06 4.2728e-06 4.2728e-06 4.2728e-06 3.9592e-06 3.9592e-06 3.9592e-06 3.9592e-06 3.9592e-06 3.9592e-06 3.9592e-06 3.9592e-06 3.9592e-06 3.9592e-06 3.9592e-06 3.9592e-06 3.9592e-06 3.9592e-06 3.9592e-06 3.9592e-06 3.9592e-06 3.9592e-06 3.9592e-06 3.9592e-06 3.9592e-06 3.9592e-06 3.9592e-06 3.9592e-06 3.9592e-06 4.0376e-06 4.0376e-06 4.0376e-06 4.0376e-06 4.0376e-06 4.0376e-06 4.0376e-06 4.0376e-06 4.0376e-06 4.0376e-06 4.0376e-06 4.0376e-06 4.0376e-06 4.0376e-06 4.0376e-06 4.0376e-06 4.0376e-06 4.0376e-06 4.0376e-06 4.0376e-06 4.0376e-06 4.0376e-06 4.0376e-06 4.0376e-06 4.0376e-06 4.116e-06 4.116e-06 4.116e-06 4.116e-06 4.116e-06 4.116e-06 4.116e-06 4.116e-06 4.116e-06 4.116e-06 4.116e-06 4.116e-06 4.116e-06 4.116e-06 4.116e-06 4.116e-06 4.116e-06 4.116e-06 4.116e-06 4.116e-06 4.116e-06 4.116e-06 4.116e-06 4.116e-06 4.116e-06 4.1944e-06 4.1944e-06 4.1944e-06 4.1944e-06 4.1944e-06 4.1944e-06 4.1944e-06 4.1944e-06 4.1944e-06 4.1944e-06 4.1944e-06 4.1944e-06 4.1944e-06 4.1944e-06 4.1944e-06 4.1944e-06 4.1944e-06 4.1944e-06 4.1944e-06 4.1944e-06 4.1944e-06 4.1944e-06 4.1944e-06 4.1944e-06 4.1944e-06 4.2728e-06 4.2728e-06 4.2728e-06 4.2728e-06 4.2728e-06 4.2728e-06 4.2728e-06 4.2728e-06 4.2728e-06 4.2728e-06 4.2728e-06 4.2728e-06 4.2728e-06 4.2728e-06 4.2728e-06 4.2728e-06 4.2728e-06 4.2728e-06 4.2728e-06 4.2728e-06 4.2728e-06 4.2728e-06 4.2728e-06 4.2728e-06 4.2728e-06 )
I3_list = '(3.9592e-06 3.9592e-06 3.9592e-06 3.9592e-06 3.9592e-06 4.0376e-06 4.0376e-06 4.0376e-06 4.0376e-06 4.0376e-06 4.116e-06 4.116e-06 4.116e-06 4.116e-06 4.116e-06 4.1944e-06 4.1944e-06 4.1944e-06 4.1944e-06 4.1944e-06 4.2728e-06 4.2728e-06 4.2728e-06 4.2728e-06 4.2728e-06 3.9592e-06 3.9592e-06 3.9592e-06 3.9592e-06 3.9592e-06 4.0376e-06 4.0376e-06 4.0376e-06 4.0376e-06 4.0376e-06 4.116e-06 4.116e-06 4.116e-06 4.116e-06 4.116e-06 4.1944e-06 4.1944e-06 4.1944e-06 4.1944e-06 4.1944e-06 4.2728e-06 4.2728e-06 4.2728e-06 4.2728e-06 4.2728e-06 3.9592e-06 3.9592e-06 3.9592e-06 3.9592e-06 3.9592e-06 4.0376e-06 4.0376e-06 4.0376e-06 4.0376e-06 4.0376e-06 4.116e-06 4.116e-06 4.116e-06 4.116e-06 4.116e-06 4.1944e-06 4.1944e-06 4.1944e-06 4.1944e-06 4.1944e-06 4.2728e-06 4.2728e-06 4.2728e-06 4.2728e-06 4.2728e-06 3.9592e-06 3.9592e-06 3.9592e-06 3.9592e-06 3.9592e-06 4.0376e-06 4.0376e-06 4.0376e-06 4.0376e-06 4.0376e-06 4.116e-06 4.116e-06 4.116e-06 4.116e-06 4.116e-06 4.1944e-06 4.1944e-06 4.1944e-06 4.1944e-06 4.1944e-06 4.2728e-06 4.2728e-06 4.2728e-06 4.2728e-06 4.2728e-06 3.9592e-06 3.9592e-06 3.9592e-06 3.9592e-06 3.9592e-06 4.0376e-06 4.0376e-06 4.0376e-06 4.0376e-06 4.0376e-06 4.116e-06 4.116e-06 4.116e-06 4.116e-06 4.116e-06 4.1944e-06 4.1944e-06 4.1944e-06 4.1944e-06 4.1944e-06 4.2728e-06 4.2728e-06 4.2728e-06 4.2728e-06 4.2728e-06 3.9592e-06 3.9592e-06 3.9592e-06 3.9592e-06 3.9592e-06 4.0376e-06 4.0376e-06 4.0376e-06 4.0376e-06 4.0376e-06 4.116e-06 4.116e-06 4.116e-06 4.116e-06 4.116e-06 4.1944e-06 4.1944e-06 4.1944e-06 4.1944e-06 4.1944e-06 4.2728e-06 4.2728e-06 4.2728e-06 4.2728e-06 4.2728e-06 3.9592e-06 3.9592e-06 3.9592e-06 3.9592e-06 3.9592e-06 4.0376e-06 4.0376e-06 4.0376e-06 4.0376e-06 4.0376e-06 4.116e-06 4.116e-06 4.116e-06 4.116e-06 4.116e-06 4.1944e-06 4.1944e-06 4.1944e-06 4.1944e-06 4.1944e-06 4.2728e-06 4.2728e-06 4.2728e-06 4.2728e-06 4.2728e-06 3.9592e-06 3.9592e-06 3.9592e-06 3.9592e-06 3.9592e-06 4.0376e-06 4.0376e-06 4.0376e-06 4.0376e-06 4.0376e-06 4.116e-06 4.116e-06 4.116e-06 4.116e-06 4.116e-06 4.1944e-06 4.1944e-06 4.1944e-06 4.1944e-06 4.1944e-06 4.2728e-06 4.2728e-06 4.2728e-06 4.2728e-06 4.2728e-06 3.9592e-06 3.9592e-06 3.9592e-06 3.9592e-06 3.9592e-06 4.0376e-06 4.0376e-06 4.0376e-06 4.0376e-06 4.0376e-06 4.116e-06 4.116e-06 4.116e-06 4.116e-06 4.116e-06 4.1944e-06 4.1944e-06 4.1944e-06 4.1944e-06 4.1944e-06 4.2728e-06 4.2728e-06 4.2728e-06 4.2728e-06 4.2728e-06 3.9592e-06 3.9592e-06 3.9592e-06 3.9592e-06 3.9592e-06 4.0376e-06 4.0376e-06 4.0376e-06 4.0376e-06 4.0376e-06 4.116e-06 4.116e-06 4.116e-06 4.116e-06 4.116e-06 4.1944e-06 4.1944e-06 4.1944e-06 4.1944e-06 4.1944e-06 4.2728e-06 4.2728e-06 4.2728e-06 4.2728e-06 4.2728e-06 3.9592e-06 3.9592e-06 3.9592e-06 3.9592e-06 3.9592e-06 4.0376e-06 4.0376e-06 4.0376e-06 4.0376e-06 4.0376e-06 4.116e-06 4.116e-06 4.116e-06 4.116e-06 4.116e-06 4.1944e-06 4.1944e-06 4.1944e-06 4.1944e-06 4.1944e-06 4.2728e-06 4.2728e-06 4.2728e-06 4.2728e-06 4.2728e-06 3.9592e-06 3.9592e-06 3.9592e-06 3.9592e-06 3.9592e-06 4.0376e-06 4.0376e-06 4.0376e-06 4.0376e-06 4.0376e-06 4.116e-06 4.116e-06 4.116e-06 4.116e-06 4.116e-06 4.1944e-06 4.1944e-06 4.1944e-06 4.1944e-06 4.1944e-06 4.2728e-06 4.2728e-06 4.2728e-06 4.2728e-06 4.2728e-06 3.9592e-06 3.9592e-06 3.9592e-06 3.9592e-06 3.9592e-06 4.0376e-06 4.0376e-06 4.0376e-06 4.0376e-06 4.0376e-06 4.116e-06 4.116e-06 4.116e-06 4.116e-06 4.116e-06 4.1944e-06 4.1944e-06 4.1944e-06 4.1944e-06 4.1944e-06 4.2728e-06 4.2728e-06 4.2728e-06 4.2728e-06 4.2728e-06 3.9592e-06 3.9592e-06 3.9592e-06 3.9592e-06 3.9592e-06 4.0376e-06 4.0376e-06 4.0376e-06 4.0376e-06 4.0376e-06 4.116e-06 4.116e-06 4.116e-06 4.116e-06 4.116e-06 4.1944e-06 4.1944e-06 4.1944e-06 4.1944e-06 4.1944e-06 4.2728e-06 4.2728e-06 4.2728e-06 4.2728e-06 4.2728e-06 3.9592e-06 3.9592e-06 3.9592e-06 3.9592e-06 3.9592e-06 4.0376e-06 4.0376e-06 4.0376e-06 4.0376e-06 4.0376e-06 4.116e-06 4.116e-06 4.116e-06 4.116e-06 4.116e-06 4.1944e-06 4.1944e-06 4.1944e-06 4.1944e-06 4.1944e-06 4.2728e-06 4.2728e-06 4.2728e-06 4.2728e-06 4.2728e-06 3.9592e-06 3.9592e-06 3.9592e-06 3.9592e-06 3.9592e-06 4.0376e-06 4.0376e-06 4.0376e-06 4.0376e-06 4.0376e-06 4.116e-06 4.116e-06 4.116e-06 4.116e-06 4.116e-06 4.1944e-06 4.1944e-06 4.1944e-06 4.1944e-06 4.1944e-06 4.2728e-06 4.2728e-06 4.2728e-06 4.2728e-06 4.2728e-06 3.9592e-06 3.9592e-06 3.9592e-06 3.9592e-06 3.9592e-06 4.0376e-06 4.0376e-06 4.0376e-06 4.0376e-06 4.0376e-06 4.116e-06 4.116e-06 4.116e-06 4.116e-06 4.116e-06 4.1944e-06 4.1944e-06 4.1944e-06 4.1944e-06 4.1944e-06 4.2728e-06 4.2728e-06 4.2728e-06 4.2728e-06 4.2728e-06 3.9592e-06 3.9592e-06 3.9592e-06 3.9592e-06 3.9592e-06 4.0376e-06 4.0376e-06 4.0376e-06 4.0376e-06 4.0376e-06 4.116e-06 4.116e-06 4.116e-06 4.116e-06 4.116e-06 4.1944e-06 4.1944e-06 4.1944e-06 4.1944e-06 4.1944e-06 4.2728e-06 4.2728e-06 4.2728e-06 4.2728e-06 4.2728e-06 3.9592e-06 3.9592e-06 3.9592e-06 3.9592e-06 3.9592e-06 4.0376e-06 4.0376e-06 4.0376e-06 4.0376e-06 4.0376e-06 4.116e-06 4.116e-06 4.116e-06 4.116e-06 4.116e-06 4.1944e-06 4.1944e-06 4.1944e-06 4.1944e-06 4.1944e-06 4.2728e-06 4.2728e-06 4.2728e-06 4.2728e-06 4.2728e-06 3.9592e-06 3.9592e-06 3.9592e-06 3.9592e-06 3.9592e-06 4.0376e-06 4.0376e-06 4.0376e-06 4.0376e-06 4.0376e-06 4.116e-06 4.116e-06 4.116e-06 4.116e-06 4.116e-06 4.1944e-06 4.1944e-06 4.1944e-06 4.1944e-06 4.1944e-06 4.2728e-06 4.2728e-06 4.2728e-06 4.2728e-06 4.2728e-06 3.9592e-06 3.9592e-06 3.9592e-06 3.9592e-06 3.9592e-06 4.0376e-06 4.0376e-06 4.0376e-06 4.0376e-06 4.0376e-06 4.116e-06 4.116e-06 4.116e-06 4.116e-06 4.116e-06 4.1944e-06 4.1944e-06 4.1944e-06 4.1944e-06 4.1944e-06 4.2728e-06 4.2728e-06 4.2728e-06 4.2728e-06 4.2728e-06 3.9592e-06 3.9592e-06 3.9592e-06 3.9592e-06 3.9592e-06 4.0376e-06 4.0376e-06 4.0376e-06 4.0376e-06 4.0376e-06 4.116e-06 4.116e-06 4.116e-06 4.116e-06 4.116e-06 4.1944e-06 4.1944e-06 4.1944e-06 4.1944e-06 4.1944e-06 4.2728e-06 4.2728e-06 4.2728e-06 4.2728e-06 4.2728e-06 3.9592e-06 3.9592e-06 3.9592e-06 3.9592e-06 3.9592e-06 4.0376e-06 4.0376e-06 4.0376e-06 4.0376e-06 4.0376e-06 4.116e-06 4.116e-06 4.116e-06 4.116e-06 4.116e-06 4.1944e-06 4.1944e-06 4.1944e-06 4.1944e-06 4.1944e-06 4.2728e-06 4.2728e-06 4.2728e-06 4.2728e-06 4.2728e-06 3.9592e-06 3.9592e-06 3.9592e-06 3.9592e-06 3.9592e-06 4.0376e-06 4.0376e-06 4.0376e-06 4.0376e-06 4.0376e-06 4.116e-06 4.116e-06 4.116e-06 4.116e-06 4.116e-06 4.1944e-06 4.1944e-06 4.1944e-06 4.1944e-06 4.1944e-06 4.2728e-06 4.2728e-06 4.2728e-06 4.2728e-06 4.2728e-06 3.9592e-06 3.9592e-06 3.9592e-06 3.9592e-06 3.9592e-06 4.0376e-06 4.0376e-06 4.0376e-06 4.0376e-06 4.0376e-06 4.116e-06 4.116e-06 4.116e-06 4.116e-06 4.116e-06 4.1944e-06 4.1944e-06 4.1944e-06 4.1944e-06 4.1944e-06 4.2728e-06 4.2728e-06 4.2728e-06 4.2728e-06 4.2728e-06 )
I4_list = '(6.1281e-06 6.0043e-06 5.8805e-06 5.7567e-06 5.6329e-06 6.1281e-06 6.0043e-06 5.8805e-06 5.7567e-06 5.6329e-06 6.1281e-06 6.0043e-06 5.8805e-06 5.7567e-06 5.6329e-06 6.1281e-06 6.0043e-06 5.8805e-06 5.7567e-06 5.6329e-06 6.1281e-06 6.0043e-06 5.8805e-06 5.7567e-06 5.6329e-06 6.1281e-06 6.0043e-06 5.8805e-06 5.7567e-06 5.6329e-06 6.1281e-06 6.0043e-06 5.8805e-06 5.7567e-06 5.6329e-06 6.1281e-06 6.0043e-06 5.8805e-06 5.7567e-06 5.6329e-06 6.1281e-06 6.0043e-06 5.8805e-06 5.7567e-06 5.6329e-06 6.1281e-06 6.0043e-06 5.8805e-06 5.7567e-06 5.6329e-06 6.1281e-06 6.0043e-06 5.8805e-06 5.7567e-06 5.6329e-06 6.1281e-06 6.0043e-06 5.8805e-06 5.7567e-06 5.6329e-06 6.1281e-06 6.0043e-06 5.8805e-06 5.7567e-06 5.6329e-06 6.1281e-06 6.0043e-06 5.8805e-06 5.7567e-06 5.6329e-06 6.1281e-06 6.0043e-06 5.8805e-06 5.7567e-06 5.6329e-06 6.1281e-06 6.0043e-06 5.8805e-06 5.7567e-06 5.6329e-06 6.1281e-06 6.0043e-06 5.8805e-06 5.7567e-06 5.6329e-06 6.1281e-06 6.0043e-06 5.8805e-06 5.7567e-06 5.6329e-06 6.1281e-06 6.0043e-06 5.8805e-06 5.7567e-06 5.6329e-06 6.1281e-06 6.0043e-06 5.8805e-06 5.7567e-06 5.6329e-06 6.1281e-06 6.0043e-06 5.8805e-06 5.7567e-06 5.6329e-06 6.1281e-06 6.0043e-06 5.8805e-06 5.7567e-06 5.6329e-06 6.1281e-06 6.0043e-06 5.8805e-06 5.7567e-06 5.6329e-06 6.1281e-06 6.0043e-06 5.8805e-06 5.7567e-06 5.6329e-06 6.1281e-06 6.0043e-06 5.8805e-06 5.7567e-06 5.6329e-06 6.1281e-06 6.0043e-06 5.8805e-06 5.7567e-06 5.6329e-06 6.1281e-06 6.0043e-06 5.8805e-06 5.7567e-06 5.6329e-06 6.1281e-06 6.0043e-06 5.8805e-06 5.7567e-06 5.6329e-06 6.1281e-06 6.0043e-06 5.8805e-06 5.7567e-06 5.6329e-06 6.1281e-06 6.0043e-06 5.8805e-06 5.7567e-06 5.6329e-06 6.1281e-06 6.0043e-06 5.8805e-06 5.7567e-06 5.6329e-06 6.1281e-06 6.0043e-06 5.8805e-06 5.7567e-06 5.6329e-06 6.1281e-06 6.0043e-06 5.8805e-06 5.7567e-06 5.6329e-06 6.1281e-06 6.0043e-06 5.8805e-06 5.7567e-06 5.6329e-06 6.1281e-06 6.0043e-06 5.8805e-06 5.7567e-06 5.6329e-06 6.1281e-06 6.0043e-06 5.8805e-06 5.7567e-06 5.6329e-06 6.1281e-06 6.0043e-06 5.8805e-06 5.7567e-06 5.6329e-06 6.1281e-06 6.0043e-06 5.8805e-06 5.7567e-06 5.6329e-06 6.1281e-06 6.0043e-06 5.8805e-06 5.7567e-06 5.6329e-06 6.1281e-06 6.0043e-06 5.8805e-06 5.7567e-06 5.6329e-06 6.1281e-06 6.0043e-06 5.8805e-06 5.7567e-06 5.6329e-06 6.1281e-06 6.0043e-06 5.8805e-06 5.7567e-06 5.6329e-06 6.1281e-06 6.0043e-06 5.8805e-06 5.7567e-06 5.6329e-06 6.1281e-06 6.0043e-06 5.8805e-06 5.7567e-06 5.6329e-06 6.1281e-06 6.0043e-06 5.8805e-06 5.7567e-06 5.6329e-06 6.1281e-06 6.0043e-06 5.8805e-06 5.7567e-06 5.6329e-06 6.1281e-06 6.0043e-06 5.8805e-06 5.7567e-06 5.6329e-06 6.1281e-06 6.0043e-06 5.8805e-06 5.7567e-06 5.6329e-06 6.1281e-06 6.0043e-06 5.8805e-06 5.7567e-06 5.6329e-06 6.1281e-06 6.0043e-06 5.8805e-06 5.7567e-06 5.6329e-06 6.1281e-06 6.0043e-06 5.8805e-06 5.7567e-06 5.6329e-06 6.1281e-06 6.0043e-06 5.8805e-06 5.7567e-06 5.6329e-06 6.1281e-06 6.0043e-06 5.8805e-06 5.7567e-06 5.6329e-06 6.1281e-06 6.0043e-06 5.8805e-06 5.7567e-06 5.6329e-06 6.1281e-06 6.0043e-06 5.8805e-06 5.7567e-06 5.6329e-06 6.1281e-06 6.0043e-06 5.8805e-06 5.7567e-06 5.6329e-06 6.1281e-06 6.0043e-06 5.8805e-06 5.7567e-06 5.6329e-06 6.1281e-06 6.0043e-06 5.8805e-06 5.7567e-06 5.6329e-06 6.1281e-06 6.0043e-06 5.8805e-06 5.7567e-06 5.6329e-06 6.1281e-06 6.0043e-06 5.8805e-06 5.7567e-06 5.6329e-06 6.1281e-06 6.0043e-06 5.8805e-06 5.7567e-06 5.6329e-06 6.1281e-06 6.0043e-06 5.8805e-06 5.7567e-06 5.6329e-06 6.1281e-06 6.0043e-06 5.8805e-06 5.7567e-06 5.6329e-06 6.1281e-06 6.0043e-06 5.8805e-06 5.7567e-06 5.6329e-06 6.1281e-06 6.0043e-06 5.8805e-06 5.7567e-06 5.6329e-06 6.1281e-06 6.0043e-06 5.8805e-06 5.7567e-06 5.6329e-06 6.1281e-06 6.0043e-06 5.8805e-06 5.7567e-06 5.6329e-06 6.1281e-06 6.0043e-06 5.8805e-06 5.7567e-06 5.6329e-06 6.1281e-06 6.0043e-06 5.8805e-06 5.7567e-06 5.6329e-06 6.1281e-06 6.0043e-06 5.8805e-06 5.7567e-06 5.6329e-06 6.1281e-06 6.0043e-06 5.8805e-06 5.7567e-06 5.6329e-06 6.1281e-06 6.0043e-06 5.8805e-06 5.7567e-06 5.6329e-06 6.1281e-06 6.0043e-06 5.8805e-06 5.7567e-06 5.6329e-06 6.1281e-06 6.0043e-06 5.8805e-06 5.7567e-06 5.6329e-06 6.1281e-06 6.0043e-06 5.8805e-06 5.7567e-06 5.6329e-06 6.1281e-06 6.0043e-06 5.8805e-06 5.7567e-06 5.6329e-06 6.1281e-06 6.0043e-06 5.8805e-06 5.7567e-06 5.6329e-06 6.1281e-06 6.0043e-06 5.8805e-06 5.7567e-06 5.6329e-06 6.1281e-06 6.0043e-06 5.8805e-06 5.7567e-06 5.6329e-06 6.1281e-06 6.0043e-06 5.8805e-06 5.7567e-06 5.6329e-06 6.1281e-06 6.0043e-06 5.8805e-06 5.7567e-06 5.6329e-06 6.1281e-06 6.0043e-06 5.8805e-06 5.7567e-06 5.6329e-06 6.1281e-06 6.0043e-06 5.8805e-06 5.7567e-06 5.6329e-06 6.1281e-06 6.0043e-06 5.8805e-06 5.7567e-06 5.6329e-06 6.1281e-06 6.0043e-06 5.8805e-06 5.7567e-06 5.6329e-06 6.1281e-06 6.0043e-06 5.8805e-06 5.7567e-06 5.6329e-06 6.1281e-06 6.0043e-06 5.8805e-06 5.7567e-06 5.6329e-06 6.1281e-06 6.0043e-06 5.8805e-06 5.7567e-06 5.6329e-06 6.1281e-06 6.0043e-06 5.8805e-06 5.7567e-06 5.6329e-06 6.1281e-06 6.0043e-06 5.8805e-06 5.7567e-06 5.6329e-06 6.1281e-06 6.0043e-06 5.8805e-06 5.7567e-06 5.6329e-06 6.1281e-06 6.0043e-06 5.8805e-06 5.7567e-06 5.6329e-06 6.1281e-06 6.0043e-06 5.8805e-06 5.7567e-06 5.6329e-06 6.1281e-06 6.0043e-06 5.8805e-06 5.7567e-06 5.6329e-06 6.1281e-06 6.0043e-06 5.8805e-06 5.7567e-06 5.6329e-06 6.1281e-06 6.0043e-06 5.8805e-06 5.7567e-06 5.6329e-06 6.1281e-06 6.0043e-06 5.8805e-06 5.7567e-06 5.6329e-06 6.1281e-06 6.0043e-06 5.8805e-06 5.7567e-06 5.6329e-06 6.1281e-06 6.0043e-06 5.8805e-06 5.7567e-06 5.6329e-06 6.1281e-06 6.0043e-06 5.8805e-06 5.7567e-06 5.6329e-06 6.1281e-06 6.0043e-06 5.8805e-06 5.7567e-06 5.6329e-06 6.1281e-06 6.0043e-06 5.8805e-06 5.7567e-06 5.6329e-06 6.1281e-06 6.0043e-06 5.8805e-06 5.7567e-06 5.6329e-06 6.1281e-06 6.0043e-06 5.8805e-06 5.7567e-06 5.6329e-06 6.1281e-06 6.0043e-06 5.8805e-06 5.7567e-06 5.6329e-06 6.1281e-06 6.0043e-06 5.8805e-06 5.7567e-06 5.6329e-06 6.1281e-06 6.0043e-06 5.8805e-06 5.7567e-06 5.6329e-06 6.1281e-06 6.0043e-06 5.8805e-06 5.7567e-06 5.6329e-06 6.1281e-06 6.0043e-06 5.8805e-06 5.7567e-06 5.6329e-06 6.1281e-06 6.0043e-06 5.8805e-06 5.7567e-06 5.6329e-06 6.1281e-06 6.0043e-06 5.8805e-06 5.7567e-06 5.6329e-06 6.1281e-06 6.0043e-06 5.8805e-06 5.7567e-06 5.6329e-06 6.1281e-06 6.0043e-06 5.8805e-06 5.7567e-06 5.6329e-06 6.1281e-06 6.0043e-06 5.8805e-06 5.7567e-06 5.6329e-06 6.1281e-06 6.0043e-06 5.8805e-06 5.7567e-06 5.6329e-06 6.1281e-06 6.0043e-06 5.8805e-06 5.7567e-06 5.6329e-06 6.1281e-06 6.0043e-06 5.8805e-06 5.7567e-06 5.6329e-06 6.1281e-06 6.0043e-06 5.8805e-06 5.7567e-06 5.6329e-06 6.1281e-06 6.0043e-06 5.8805e-06 5.7567e-06 5.6329e-06 6.1281e-06 6.0043e-06 5.8805e-06 5.7567e-06 5.6329e-06 6.1281e-06 6.0043e-06 5.8805e-06 5.7567e-06 5.6329e-06 6.1281e-06 6.0043e-06 5.8805e-06 5.7567e-06 5.6329e-06 6.1281e-06 6.0043e-06 5.8805e-06 5.7567e-06 5.6329e-06 6.1281e-06 6.0043e-06 5.8805e-06 5.7567e-06 5.6329e-06 6.1281e-06 6.0043e-06 5.8805e-06 5.7567e-06 5.6329e-06 )

(foreach vc vc_list

(foreach (i1 i2 i3 i4) I1_list I2_list I3_list I4_list

Write_stimuli(i1 i2 i3 i4 vdd vc)

wta_simulation(i1 i2 i3 i4 vdd vc)

));
